*===========================================*
* CMOS Inverter Transient Analysis          *
* Task 2 Q3: Variant 2 - FASTER             *
* Wnmos=15um, Wpmos=37.5um (ratio 2.5:1)    *
* Even faster switching                     *
*===========================================*

* --- Power Supply ---
VDD Vdd 0 DC 5

* --- Input Signal: PULSE Source ---
Vin in 0 PULSE(0 5 0ns 5ns 5ns 50ns 100ns)

* --- NMOS Transistor M1 (Pull-down) ---
* Larger width for even faster fall time
M1 out in 0 0 NMOSLEVEL1 W=15u L=1u

* --- PMOS Transistor M2 (Pull-up) ---
* Maintains 2.5:1 ratio for symmetry
M2 out in Vdd Vdd PMOSLEVEL1 W=37.5u L=1u

* --- Load Capacitance ---
CL out 0 10p

* --- Transient Analysis ---
.tran 0.1ns 200ns

* --- Transistor Models ---
.model NMOSLEVEL1 NMOS LEVEL=1 VTO=0.4 KP=200u LAMBDA=0.02
.model PMOSLEVEL1 PMOS LEVEL=1 VTO=-0.4 KP=80u LAMBDA=0.02

.end
