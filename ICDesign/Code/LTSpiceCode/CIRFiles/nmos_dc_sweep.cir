*===========================================*
* Lab 1 Task 1: NMOS I-V DC Sweep           *
* Multiple VGS curves                       *
*===========================================*

* --- Gate Voltage Parameter ---
.param VGSVAL=1.2

* --- Voltage Sources ---
* Gate-source voltage (parameterised for sweep)
VGS G 0 DC {VGSVAL}

* Drain-source voltage (primary sweep variable)
VDS D 0 DC 0

* --- NMOS Transistor ---
* Terminals: Drain=D, Gate=G, Source=0, Bulk=0
* Width=10um, Length=1um
M1 D G 0 0 NLEVEL1 W=10u L=1u

* --- Shichman-Hodges Level 1 Model ---
* VTO = Threshold voltage (0.4V)
* KP = Transconductance parameter (200uA/V^2)
* LAMBDA = Channel-length modulation (0.02/V)
.model NLEVEL1 NMOS LEVEL=1 VTO=0.4 KP=200u LAMBDA=0.02

* --- DC Sweep Analysis ---
* Primary: VDS from 0V to 1.2V in 10mV steps
* Secondary: VGS from 0.4V to 1.2V in 0.2V steps (5 curves)
.dc VDS 0 1.2 0.01 VGS 0.4 1.2 0.2

* --- Plot drain current ---
.plot DC I(M1)

.end
