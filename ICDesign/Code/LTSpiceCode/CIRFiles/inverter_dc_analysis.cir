* CMOS Inverter DC Sweep Analysis
* =====================================
* This netlist performs DC sweep analysis of a basic CMOS inverter

* --- Power Supply ---
VDD Vdd 0 DC 5
* VDD: DC voltage source named "VDD"
* Vdd: Positive terminal connected to node "Vdd" (5V rail)
* 0: Negative terminal connected to ground (node 0)
* DC 5: Constant 5V DC voltage

* --- Input Voltage Source ---
Vin in 0 DC 0
* Vin: DC voltage source named "Vin" (will be swept)
* in: Positive terminal connected to node "in" (input node)
* 0: Negative terminal connected to ground
* DC 0: Starting value (overridden by .dc sweep)

* --- NMOS Transistor (Pull-down) ---
M1 out in 0 0 NMOSLEVEL1 W=10u L=1u
* M1: NMOS transistor instance name
* out: Drain terminal (output node)
* in: Gate terminal (input node)
* 0: Source terminal (ground)
* 0: Bulk/substrate terminal (ground for NMOS)
* NMOSLEVEL1: Model name (defined below)
* W=10u: Channel width = 10 micrometers
* L=1u: Channel length = 1 micrometer

* --- PMOS Transistor (Pull-up) ---
M2 out in Vdd Vdd PMOSLEVEL1 W=20u L=1u
* M2: PMOS transistor instance name
* out: Drain terminal (output node)
* in: Gate terminal (input node)
* Vdd: Source terminal (connected to VDD for PMOS)
* Vdd: Bulk/substrate terminal (connected to VDD for PMOS)
* PMOSLEVEL1: Model name (defined below)
* W=20u: Channel width = 20 micrometers (wider for equal drive strength)
* L=1u: Channel length = 1 micrometer

* --- DC Sweep Analysis ---
.dc Vin 0 5 0.01
* .dc: DC sweep analysis command
* Vin: Source to sweep (input voltage)
* 0: Start voltage (0V)
* 5: Stop voltage (5V)
* 0.01: Step size (10mV increments)

* --- Plot Command ---
.plot DC V(in) V(out)
* .plot: Command to plot results
* DC: Analysis type (DC sweep)
* V(in): Plot input voltage
* V(out): Plot output voltage (inverter transfer curve)

* --- Transistor Models (Level 1 - Shichman-Hodges) ---
.model NMOSLEVEL1 NMOS LEVEL=1 VTO=1.0 KP=200u LAMBDA=0.02
* .model: Model definition command
* NMOSLEVEL1: Model name for NMOS
* NMOS: N-channel MOSFET type
* LEVEL=1: Simple Shichman-Hodges model
* VTO=1.0: Threshold voltage = 1.0V (Vthn)
* KP=200u: Transconductance parameter = 200 uA/V^2 (un*Cox)
* LAMBDA=0.02: Channel-length modulation parameter = 0.02 V^-1

.model PMOSLEVEL1 PMOS LEVEL=1 VTO=-1.0 KP=100u LAMBDA=0.02
* .model: Model definition command
* PMOSLEVEL1: Model name for PMOS
* PMOS: P-channel MOSFET type
* LEVEL=1: Simple Shichman-Hodges model
* VTO=-1.0: Threshold voltage = -1.0V (Vthp, negative for PMOS)
* KP=100u: Transconductance parameter = 100 uA/V^2 (typically ~0.5× NMOS)
* LAMBDA=0.02: Channel-length modulation parameter = 0.02 V^-1

* --- End of Netlist ---
.end
