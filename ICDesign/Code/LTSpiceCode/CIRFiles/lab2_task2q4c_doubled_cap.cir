*===========================================*
* Lab 2 Task 2 Q4c: Doubled Load Capacitance
* CL = 20pF (doubled from 10pF)
* Demonstrates: delays double when C doubles
*===========================================*

* --- Power Supply ---
VDD Vdd 0 DC 5

* --- Input Signal: PULSE Source ---
Vin in 0 PULSE(0 5 0ns 5ns 5ns 50ns 100ns)

* --- Transistors (Original sizing) ---
M1 out in 0 0 NMOSLEVEL1 W=10u L=1u
M2 out in Vdd Vdd PMOSLEVEL1 W=20u L=1u

* --- Load Capacitance DOUBLED ---
* tau = RC, so doubling C doubles all delays
CL out 0 20p

* --- Transient Analysis ---
.tran 0.1ns 200ns

* --- Transistor Models ---
.model NMOSLEVEL1 NMOS LEVEL=1 VTO=0.4 KP=200u LAMBDA=0.02
.model PMOSLEVEL1 PMOS LEVEL=1 VTO=-0.4 KP=80u LAMBDA=0.02

*===========================================*
* AUTOMATED TIMING MEASUREMENTS
*===========================================*

* Rise time: 10% (0.5V) to 90% (4.5V)
.meas tran t_rise TRIG V(out) VAL=0.5 RISE=1 TARG V(out) VAL=4.5 RISE=1

* Fall time: 90% (4.5V) to 10% (0.5V)
.meas tran t_fall TRIG V(out) VAL=4.5 FALL=1 TARG V(out) VAL=0.5 FALL=1

* tPHL: Input rises past 50% -> Output falls past 50%
.meas tran tPHL TRIG V(in) VAL=2.5 RISE=1 TARG V(out) VAL=2.5 FALL=1

* tPLH: Input falls past 50% -> Output rises past 50%
.meas tran tPLH TRIG V(in) VAL=2.5 FALL=1 TARG V(out) VAL=2.5 RISE=1

* Average propagation delay
.meas tran t_prop PARAM='(tPHL+tPLH)/2'

* Delay asymmetry
.meas tran t_skew PARAM='abs(tPHL-tPLH)'

*===========================================*
* EXPECTED RESULTS:
* t_rise ~ 26ns (spec: <= 15ns) FAIL
* t_fall ~ 21ns (spec: <= 10ns) FAIL
* tau = RC, so doubling C doubles all delays
*===========================================*

.end
