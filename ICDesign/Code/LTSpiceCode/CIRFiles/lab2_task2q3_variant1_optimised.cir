*===========================================*
* Lab 2 Task 2 Q3: Variant 1 - OPTIMISED
* Wnmos=12um, Wpmos=30um (2.5:1 ratio)
* RECOMMENDED DESIGN - MEETS ALL SPECS
*===========================================*

* --- Power Supply ---
VDD Vdd 0 DC 5

* --- Input Signal: PULSE Source ---
Vin in 0 PULSE(0 5 0ns 5ns 5ns 50ns 100ns)

* --- NMOS Transistor M1 (Pull-down) ---
* Increased from 10um to 12um to reduce fall time
M1 out in 0 0 NMOSLEVEL1 W=12u L=1u

* --- PMOS Transistor M2 (Pull-up) ---
* 2.5:1 ratio matches KPn/KPp = 200/80 = 2.5
* This compensates for mobility difference, giving symmetric delays
M2 out in Vdd Vdd PMOSLEVEL1 W=30u L=1u

* --- Load Capacitance ---
CL out 0 10p

* --- Transient Analysis ---
.tran 0.1ns 200ns

* --- Transistor Models ---
.model NMOSLEVEL1 NMOS LEVEL=1 VTO=0.4 KP=200u LAMBDA=0.02
.model PMOSLEVEL1 PMOS LEVEL=1 VTO=-0.4 KP=80u LAMBDA=0.02

*===========================================*
* AUTOMATED TIMING MEASUREMENTS
* View results: Ctrl+L (SPICE Error Log)
*===========================================*

* Rise time: 10% (0.5V) to 90% (4.5V)
.meas tran t_rise TRIG V(out) VAL=0.5 RISE=1 TARG V(out) VAL=4.5 RISE=1

* Fall time: 90% (4.5V) to 10% (0.5V)
.meas tran t_fall TRIG V(out) VAL=4.5 FALL=1 TARG V(out) VAL=0.5 FALL=1

* tPHL: Input rises past 50% -> Output falls past 50%
.meas tran tPHL TRIG V(in) VAL=2.5 RISE=1 TARG V(out) VAL=2.5 FALL=1

* tPLH: Input falls past 50% -> Output rises past 50%
.meas tran tPLH TRIG V(in) VAL=2.5 FALL=1 TARG V(out) VAL=2.5 RISE=1

* Average propagation delay
.meas tran t_prop PARAM='(tPHL+tPLH)/2'

* Delay asymmetry (spec: < 2ns)
.meas tran t_skew PARAM='abs(tPHL-tPLH)'

*===========================================*
* EXPECTED RESULTS:
* t_rise ~ 8.7ns (spec: <= 15ns) PASS
* t_fall ~ 8.7ns (spec: <= 10ns) PASS
* t_skew ~ 0ns  (spec: <= 2ns)  PASS
*===========================================*

.end
