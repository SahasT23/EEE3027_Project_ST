*===========================================*
* CMOS Inverter Transient Analysis          *
* Task 2 Q1: Original Design                *
* Wnmos=10um, Wpmos=20um                    *
*===========================================*

* --- Power Supply ---
VDD Vdd 0 DC 5

* --- Input Signal: PULSE Source ---
* PULSE(Vlow Vhigh Tdelay Trise Tfall Tpulse Tperiod)
* 0-5V pulse, 5ns rise/fall, 50ns pulse width, 100ns period
Vin in 0 PULSE(0 5 0ns 5ns 5ns 50ns 100ns)

* --- NMOS Transistor M1 (Pull-down) ---
M1 out in 0 0 NMOSLEVEL1 W=10u L=1u

* --- PMOS Transistor M2 (Pull-up) ---
M2 out in Vdd Vdd PMOSLEVEL1 W=20u L=1u

* --- Load Capacitance ---
CL out 0 10p

* --- Transient Analysis ---
* Simulate from 0 to 200ns with 0.1ns timestep
.tran 0.1ns 200ns

* --- Transistor Models ---
.model NMOSLEVEL1 NMOS LEVEL=1 VTO=0.4 KP=200u LAMBDA=0.02
.model PMOSLEVEL1 PMOS LEVEL=1 VTO=-0.4 KP=80u LAMBDA=0.02

.end
