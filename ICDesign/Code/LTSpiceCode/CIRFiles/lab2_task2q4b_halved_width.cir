*===========================================*
* Lab 2 Task 2 Q4b: Halved Transistor Widths
* Wnmos=5um, Wpmos=10um
* Demonstrates: delays double when W halves
*===========================================*

* --- Power Supply ---
VDD Vdd 0 DC 5

* --- Input Signal: PULSE Source ---
Vin in 0 PULSE(0 5 0ns 5ns 5ns 50ns 100ns)

* --- Transistors HALVED from original ---
* Ron doubles -> delays double
M1 out in 0 0 NMOSLEVEL1 W=5u L=1u
M2 out in Vdd Vdd PMOSLEVEL1 W=10u L=1u

* --- Load Capacitance ---
CL out 0 10p

* --- Transient Analysis ---
.tran 0.1ns 200ns

* --- Transistor Models ---
.model NMOSLEVEL1 NMOS LEVEL=1 VTO=0.4 KP=200u LAMBDA=0.02
.model PMOSLEVEL1 PMOS LEVEL=1 VTO=-0.4 KP=80u LAMBDA=0.02

*===========================================*
* AUTOMATED TIMING MEASUREMENTS
*===========================================*

* Rise time: 10% (0.5V) to 90% (4.5V)
.meas tran t_rise TRIG V(out) VAL=0.5 RISE=1 TARG V(out) VAL=4.5 RISE=1

* Fall time: 90% (4.5V) to 10% (0.5V)
.meas tran t_fall TRIG V(out) VAL=4.5 FALL=1 TARG V(out) VAL=0.5 FALL=1

* tPHL: Input rises past 50% -> Output falls past 50%
.meas tran tPHL TRIG V(in) VAL=2.5 RISE=1 TARG V(out) VAL=2.5 FALL=1

* tPLH: Input falls past 50% -> Output rises past 50%
.meas tran tPLH TRIG V(in) VAL=2.5 FALL=1 TARG V(out) VAL=2.5 RISE=1

* Average propagation delay
.meas tran t_prop PARAM='(tPHL+tPLH)/2'

* Delay asymmetry
.meas tran t_skew PARAM='abs(tPHL-tPLH)'

*===========================================*
* EXPECTED RESULTS:
* t_rise ~ 26ns (spec: <= 15ns) FAIL
* t_fall ~ 21ns (spec: <= 10ns) FAIL
* Ron proportional to 1/W, so halving W doubles delays
*===========================================*

.end
