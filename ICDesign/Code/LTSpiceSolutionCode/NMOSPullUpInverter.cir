* NMOS Pull-up Inverter
* =====================================================

* --- Power Supply ---
VDD Vdd 0 DC 5

* --- Input Voltage Source ---
Vin in 0 DC 0

* --- NMOS Transistor (Pull-down) ---
M1 out in 0 0 NMOSLEVEL1 W=10u L=1u
* M1: Pull-down NMOS (same as before)
* Drain=out, Gate=in, Source=GND, Bulk=GND

* --- NMOS Transistor (Pull-up) - THE PROBLEM! ---
M2 out in Vdd Vdd NMOSLEVEL1 W=20u L=1u
* M2: Pull-up NMOS (changed from PMOS to NMOS!)
* Drain=out, Gate=in, Source=Vdd, Bulk=Vdd
* WARNING: This configuration has serious limitations!

* --- DC Sweep Analysis ---
.dc Vin 0 5 0.01

* --- Plot Command ---
.plot DC V(in) V(out)

* --- Transistor Models ---
.model NMOSLEVEL1 NMOS LEVEL=1 VTO=1.0 KP=200u LAMBDA=0.02

* --- End ---
.end
