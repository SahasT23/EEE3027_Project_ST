*===========================================*
* NMOS I_D vs V_DS with Multiple VGS Curves
* Sweep VDS from 0V to 1.2V
* AND sweep VGS from 0.4V to 1.2V in 0.2V steps
* This creates a FAMILY OF CURVES
*===========================================*

* --- VOLTAGE SOURCES ---

VGS G 0 DC 0
* VGS: Gate voltage source name
* G: Positive terminal at gate node
* 0: Negative terminal at ground
* DC: DC voltage source type
* 0: Initial value (will be swept by .dc command)
* Purpose: This will be swept to create multiple curves
* Unlike before, this is NOT constant - it will vary!

VDS D 0 DC 0
* VDS: Drain voltage source name
* D: Positive terminal at drain node
* 0: Negative terminal at ground
* DC: DC voltage source
* 0: Initial value (will be swept by .dc command)
* Purpose: Controls VDS for the I-V characteristic
* This is the PRIMARY sweep variable (x-axis)

* --- TRANSISTOR DEFINITION ---

M1 D G 0 0 NLEVEL1 W=10u L=1u
* M1: NMOS transistor instance
* D: Drain connected to node D
* G: Gate connected to node G
* 0 (first): Source connected to ground
* 0 (second): Bulk/Body connected to ground
* NLEVEL1: Model name (defined below)
* W=10u: Channel width = 10 micrometers
* L=1u: Channel length = 1 micrometer
* BETA = (W/L) × KP = 10 × 200u = 2mA/V^2

* --- TRANSISTOR MODEL ---

.model NLEVEL1 NMOS LEVEL=1 VTO=0.4 KP=200u LAMBDA=0.02
* .model: Define transistor model parameters
* NLEVEL1: Model name (matches M1 definition)
* NMOS: N-channel MOSFET
* LEVEL=1: Shichman-Hodges model (basic square-law)
*
* VTO=0.4: Threshold voltage = 0.4V
*    Transistor turns ON when VGS > 0.4V
*    This determines which curves will show current
*
* KP=200u: Process transconductance = 200uA/V^2
*    Affects how much current flows
*    Higher KP = more current
*
* LAMBDA=0.02: Channel-length modulation = 0.02 V⁻¹
*    Creates slight upward slope in saturation
*    Models output resistance effect

* --- NESTED DC SWEEP (THE KEY PART!) ---

.dc VDS 0 1.2 0.01 VGS 0.4 1.2 0.2
* .dc: DC sweep analysis command
*
* PRIMARY SWEEP (inner loop - x-axis):
*    VDS: Sweep the drain-source voltage
*    0: Start at 0 Volts
*    1.2: End at 1.2 Volts
*    0.01: Step size = 10mV (120 points per curve)
*    This is swept COMPLETELY for each VGS value
*
* SECONDARY SWEEP (outer loop - creates multiple curves):
*    VGS: Sweep the gate-source voltage
*    0.4: Start at 0.4V (= threshold voltage)
*    1.2: End at 1.2V
*    0.2: Step size = 0.2V
*    Number of curves = (1.2-0.4)/0.2 + 1 = 5 curves
*
* HOW IT WORKS:
* 1. Set VGS = 0.4V, sweep VDS from 0 to 1.2V → First curve
* 2. Set VGS = 0.6V, sweep VDS from 0 to 1.2V → Second curve
* 3. Set VGS = 0.8V, sweep VDS from 0 to 1.2V → Third curve
* 4. Set VGS = 1.0V, sweep VDS from 0 to 1.2V → Fourth curve
* 5. Set VGS = 1.2V, sweep VDS from 0 to 1.2V → Fifth curve
*
* RESULT: 5 I-V curves, one for each VGS value
* Each curve shows different saturation current level

* --- OUTPUT SPECIFICATION ---

.plot DC I(M1)
* .plot: Plot command
* DC: Use DC sweep results
* I(M1): Plot drain current
* This will automatically plot ALL curves
* Each curve corresponds to a different VGS
* LTspice will color-code them differently

* --- END OF NETLIST ---

.end
* Required end statement

*===========================================*
* EXPECTED CURVES:
*
* Curve 1 (VGS = 0.4V):
*    - Barely turns on (VGS = Vth)
*    - Very low current
*    - Saturation at Ids(approx) = 0mA
*
* Curve 2 (VGS = 0.6V):
*    - Vdssat = 0.6 - 0.4 = 0.2V
*    - Saturation current(approx) = 0.04mA
*    - Ids_sat = (BETA/2)(VGS-Vth)^2 = 1m×(0.2)^2 = 0.04mA
*
* Curve 3 (VGS = 0.8V):
*    - Vdssat = 0.8 - 0.4 = 0.4V
*    - Saturation current(approx) = 0.16mA
*    - Ids_sat = 1m×(0.4)^2 = 0.16mA
*
* Curve 4 (VGS = 1.0V):
*    - Vdssat = 1.0 - 0.4 = 0.6V
*    - Saturation current(approx) = 0.36mA
*    - Ids_sat = 1m×(0.6)^2 = 0.36mA
*
* Curve 5 (VGS = 1.2V):
*    - Vdssat = 1.2 - 0.4 = 0.8V
*    - Saturation current(approx) = 0.64mA
*    - Ids_sat = 1m×(0.8)^2 = 0.64mA
*
* Each curve:
*    - Linear region: 0 to (VGS - Vth)
*    - Saturation region: (VGS - Vth) to 1.2V
*    - Higher VGS → higher saturation current
*    - Saturation current proportional to (VGS-Vth)^2
*===========================================*
